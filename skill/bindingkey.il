hiSetBindKeys( "Layout" list(
    list("Ctrl<Key>a"  "plot_drc_db_in_virtuoso(\"/home/study/ODE/sample/drc.cal\")"   )

))
